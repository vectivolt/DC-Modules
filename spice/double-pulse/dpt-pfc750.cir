* dpt-pfc750.cir — Level-1 double-pulse test, PFC position (SIC750_10R vs JBS1200_40 freewheel)
* Bus = VBUS/2 = 425 V (Vienna commutation cell). Load = actual PFC choke value at bias (42 uH).
* Gate: +18/-4 V, Rg_on/Rg_off swept externally via .csparam override (see run-dpt.sh loop).
* Parasitics (analytical estimates, §39; PCB extraction NOT performed yet — documented):
*   L_bus 18nH (film cap loop), L_d 8nH (drain lead+trace), L_s_pwr 6nH (power source path),
*   L_kelvin 1.5nH (Kelvin source), L_g 6nH (gate loop)
.include ../models/sic-behavioral.lib

.param VBUS=425 ILOAD=78 RGON=4.7 RGOFF=2.2 LLOAD=42u
.param TCHARGE={LLOAD*ILOAD/VBUS}

VBUS busP 0 {VBUS}
CBUS busP 0 40u ic={VBUS}
LBUS busP busPl 18n

* freewheel JBS from switch node to bus+
DFW sw busPl JBS1200_40
LLOAD busPl sw {LLOAD} ic=0

* DUT with package/loop parasitics
LD busDl sw 8n
* note: DUT drain at 'sw' via LD from node d
MDUT d g s_k SIC750_10R
LDD sw d 1n
LSP s_k s_pwr 1.5n
LS2 s_pwr 0 6n
* gate drive: two-level pulse train (double pulse), separate on/off resistors via ideal diodes
VDRV drv s_k PULSE(-4 18 1u {TCHARGE} 20n 20n 3u)
* second pulse
VDRV2 drv2 0 0
RGON drv gon {RGON}
DGON gon g DIDEAL
RGOFF drv goff {RGOFF}
DGOFF g goff DIDEAL
.model DIDEAL D(Is=1e-6 N=0.05)

.tran 0.2n {TCHARGE}+5u uic
.option method=gear reltol=1e-3 abstol=1n vntol=1u

.control
set filetype=ascii
* pulse 1 charges LLOAD to ~ILOAD; measure turn-off at end of pulse 1 and turn-on of pulse 2
run
* find turn-off event (end of first pulse at t = 1u + TCHARGE)
meas tran vds_peak MAX v(sw,s_pwr) from=$&tcharge to={1u+$&tcharge+1u}
let vds = v(sw)-v(s_pwr)
let id = i(LD)? 0 : 0
wrdata dpt_last.csv v(sw) v(g,s_k) i(LLOAD)
echo RESULT vds_peak = $&vds_peak
.endc
.end
