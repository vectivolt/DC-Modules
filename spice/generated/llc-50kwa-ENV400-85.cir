* E67 full-bridge LLC 50kwa:FB n2/Lr3.56u/Cr11x33n/Lm35.6u/Coss2500p VBUS=830 VBANK=400 fsw=151.243k PFM tdeadA=120n tdeadB=120n
* E81 Coss model: body-diode junction Cjo=9.750n Vj=2 M=0.5 per position (Qoss(800 V)=742 nC) + linear snubber 2000 pF drain-source on BOTH devices
.model DREC D(Is=1e-9 N=1.8 Rs=0.022)
.model DBODY D(Is=1e-12 N=4 Rs=0.03 Cjo=9.75034e-9 Vj=2 M=0.5)
VBUS bus 0 DC 830

VGHA ghA 0 PULSE(0 1 0.00000e+0 20n 20n 3.16594e-6 6.61187e-6)
VGLA glA 0 PULSE(0 1 3.30594e-6 20n 20n 3.16594e-6 6.61187e-6)
VHSA bus bhA DC 0
BSHA bhA legA I=v(bhA,legA)*(2e-5+v(ghA)*57.14285714285714)
BSLA legA 0 I=v(legA)*(2e-5+v(glA)*57.14285714285714)
DBHA legA bhA DBODY
DBLA 0 legA DBODY
CSHA bhA legA 2.00000e-9
CSLA legA 0 2.00000e-9

VGHB ghB 0 PULSE(0 1 3.30594e-6 20n 20n 3.16594e-6 6.61187e-6)
VGLB glB 0 PULSE(0 1 0.00000e+0 20n 20n 3.16594e-6 6.61187e-6)
VHSB bus bhB DC 0
BSHB bhB legB I=v(bhB,legB)*(2e-5+v(ghB)*57.14285714285714)
BSLB legB 0 I=v(legB)*(2e-5+v(glB)*57.14285714285714)
DBHB legB bhB DBODY
DBLB 0 legB DBODY
CSHB bhB legB 2.00000e-9
CSLB legB 0 2.00000e-9
VSP legA tk DC 0
CR tk tkb 3.63000e-7 ic=0
LR tkb pri 3.56000e-6
RW pri prib 0.004
LM prib legB 3.56000e-5
LS1 s1w s1n 8.90000e-6
RW1 s1w s1p 0.002
VSA s1p s1q DC 0
LS2 s2w s2n 8.90000e-6
RW2 s2w s2p 0.002
VSB s2p s2q DC 0
KA LM LS1 0.9999
KB LM LS2 0.9999
KC LS1 LS2 0.9999
RB1 s1q 0ba 1meg
RB2 s1n 0ba 1meg
RB3 s2q 0bb 1meg
RB4 s2n 0bb 1meg
DA1 s1q bkA DREC
DA2 0ba s1q DREC
DA3 s1n bkA DREC
DA4 0ba s1n DREC
DB1 s2q bkB DREC
DB2 0bb s2q DREC
DB3 s2n bkB DREC
DB4 0bb s2n DREC
VBKA bkA 0ba DC 400
VBKB bkB 0bb DC 400
RTA 0ba 0 1u
RTB 0bb 0 1u
.tran 30n 4.00000e-4 2.94210e-4 15n uic
.option method=gear reltol=1e-3 abstol=1e-6 vntol=1u itl4=100
.control
set filetype=ascii
run
let vcr = v(tk)-v(tkb)
wrdata llc-50kwa-ENV400-85.out i(VSP) i(VSA) i(VSB) vcr v(legA) v(legB) v(ghA) v(glA) v(ghB) v(glB) i(VBKA) i(VBKB) i(VHSA)
quit
.endc
.end
