* precharge RP=22
.model DPWR D(Is=1e-9 N=1.8 Rs=0.011)
BA a neut V=387.8*sin(6.2831853*50*time)
BB b neut V=387.8*sin(6.2831853*50*time-2.0943951)
BC c neut V=387.8*sin(6.2831853*50*time+2.0943951)
RNEUT neut 0 10meg
DTA a p DPWR
DBA n a DPWR
DTB b p DPWR
DBB n b DPWR
DTC c p DPWR
DBC n c DPWR
RPRE p pc0 22
VPR pc0 pc DC 0
CP pc mid 2350u ic=0
CN mid n 2350u ic=0
VN n 0 0
.option itl4=200 gmin=1e-10 abstol=1e-4 chgtol=1e-12
.tran 20u 0.6 0 50u uic
.control
set filetype=ascii
run
wrdata pre-22.out v(pc,n) i(VPR)
quit
.endc
.end
