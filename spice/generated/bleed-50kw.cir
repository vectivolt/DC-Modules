* bank-bleed: 0.0000308 F from 500 V into 8800 ohm
CB p 0 0.0000308 ic=500
RD p 0 8800
.tran 0.00040656000000000004 1.6262400000000001 0 0.0008131200000000001 uic
.control
set filetype=ascii
run
wrdata bleed-50kw.out v(p)
quit
.endc
.end
