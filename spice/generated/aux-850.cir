* aux flyback rev B VIN=850 (full bus, E26)
VIN vin 0 DC 850
* primary: Lp 550u with switch to ground via sense R; RCD clamp
LP vin sw 550u
BSW sw csn I=v(sw,csn)*(1e-7+v(g)*20)
RCS csn 0 0.55
RCSF csn csnf 200
CCSF csnf 0 1n
DCL sw cl DCLP
CCL cl vin 10n ic=0
RCL cl vin 94k
.model DCLP D(Is=1e-9 N=1.8 Rs=0.1)
* secondaries (coupled): n24=0.206 → 23.3u, n15=0.131 → 9.4u
LS24 s24a 0 23.3u
LS15 s15a 0 9.4u
K1 LP LS24 0.998
K2 LP LS15 0.998
K3 LS24 LS15 0.998
D24 s24a v24 DSCH
D15 s15a v15 DSCH
.model DSCH D(Is=1e-7 N=1.05 Rs=0.02)
C24 v24 0 220u ic=0
C15 v15 0 220u ic=0
* loads: 24 V hold 0.5 A stepping to 1.8 A (all relays pull-in + fans, CB-7 case); 15 V 0.8 A
BL24 v24 0 I=max(v(v24),0)/24*(0.5+1.3*u(time-0.012))
RL15 v15 0 18.75
* control: voltage-mode P on 24 V rail, duty 0.03..0.45, soft-start ramp; 65 kHz sawtooth
BTRI tri 0 V=time*65000-floor(time*65000)
BDUT dut 0 V=min(max(0.35*(24.5-v(v24f)),0.03),min(0.45,time/5m+0.03))
* PWM AND cycle-by-cycle CS clamp (1.0 V / 0.55 R = 1.8 A) — as the real current-mode IC
BGT g 0 V=min(max((v(dut)-v(tri))*60+0.5,0),1)*min(max((1.0-v(csnf))*60+0.5,0),1)
RF1 v24 v24f 1k
CF1 v24f 0 100n
.tran 0.4u 0.02 0 0.2u uic
.option method=gear reltol=2e-3 abstol=1e-6 itl4=100
.control
set filetype=ascii
run
wrdata aux-850.out v(v24) v(v15) i(VIN)
quit
.endc
.end
