* parallel closure with 20 V mismatch, 50kwa film bank 30.8 uF/bank, loop 300 nH
CA a 0 3.08000e-5 ic=410
CB b 0 3.08000e-5 ic=390
* relay closes at t=1ms: contact R ramps 1meg -> 2 mOhm over 100 us (arc/bounce abstracted)
BREL a c I=v(a,c)/(0.002+1e6*(1-min(max((time-1m)/100u,0),1)))
LW c b 300n
.tran 0.2u 6m 0 0.1u uic
.option method=gear reltol=1e-3
.control
set filetype=ascii
run
wrdata sp-50kwa-20V-300n.out v(a,b) i(LW)
quit
.endc
.end
