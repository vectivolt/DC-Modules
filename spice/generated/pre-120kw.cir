* precharge per-SKU: 475 VAC, 2x33R in L1/L2, 6-pulse into 4.23 mF eq
VA a 0 SIN(0 387.83587594066995 50 0 0 0)
VB b 0 SIN(0 387.83587594066995 50 0 0 120)
VC c 0 SIN(0 387.83587594066995 50 0 0 240)
RPA a af 33
RPB b bf 33
RC c cf 0.01
D1 af p DR
D2 bf p DR
D3 cf p DR
D4 n af DR
D5 n bf DR
D6 n cf DR
.model DR D(Is=1e-9 N=1.5 Rs=0.01)
CBUS p n 0.00423 ic=0
RBLD p n 200k
.tran 50u 1.2 0 20u uic
.option method=gear reltol=1e-3 abstol=1e-6
.control
set filetype=ascii
run
wrdata pre-120kw.out v(p,n) i(VA)
quit
.endc
.end
