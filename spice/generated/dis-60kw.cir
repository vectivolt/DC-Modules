* bus-discharge: 0.002115 F from 850 V into 640 ohm
CB p 0 0.002115 ic=850
RD p 0 640
.tran 0.0019249999999999998 7.699999999999999 0 0.0038499999999999997 uic
.control
set filetype=ascii
run
wrdata dis-60kw.out v(p)
quit
.endc
.end
