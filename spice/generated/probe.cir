* vienna 3ph 30kW VLL=330 P=31088
.include ../models/sic-behavioral.lib
.model DPWR D(Is=1e-12 N=1.05 Rs=0.011)
.model SWMOD SW(Ron=0.026 Roff=1e6 Vt=0.5 Vh=0.05)
VA a0 0 DC 0
BA a 0 V=269.44387170614965*sin(6.2831853*50*time)
BB b 0 V=269.44387170614965*sin(6.2831853*50*time-2.0943951)
BC c 0 V=269.44387170614965*sin(6.2831853*50*time+2.0943951)
LA a la1 100u ic=0
VSA la1 pha DC 0
LB b lb1 100u ic=0
VSB lb1 phb DC 0
LC c lc1 100u ic=0
VSC lc1 phc DC 0
* three-level cell per phase: top/bottom diodes + bidirectional switch to mid
DTA pha p DPWR
DBA n pha DPWR
DTB phb p DPWR
DBB n phb DPWR
DTC phc p DPWR
DBC n phc DPWR
SA pha mid ga 0 SWMOD
SB phb mid gb 0 SWMOD
SC phc mid gc 0 SWMOD
CP p mid 0.00235 ic=400
CN mid n 0.00235 ic=400
RBALP p mid 100k
RBALN mid n 100k
VN n 0 DC 0
RLOAD p n 20.59
* modulation
BTRI tri 0 V=abs(2*(time*50000-floor(time*50000))-1)
BDA da 0 V=min(max(1-abs(v(a))/(v(p)/2+1)+0.0044*(77.7*abs(sin(6.2831853*50*time))-abs(i(VSA)))+0.004*(v(p)/2-v(mid))*sgn(i(VSA)),0.02),0.98)
BDB db 0 V=min(max(1-abs(v(b))/(v(p)/2+1)+0.0044*(77.7*abs(sin(6.2831853*50*time-2.0943951))-abs(i(VSB)))+0.004*(v(p)/2-v(mid))*sgn(i(VSB)),0.02),0.98)
BDC dc 0 V=min(max(1-abs(v(c))/(v(p)/2+1)+0.0044*(77.7*abs(sin(6.2831853*50*time+2.0943951))-abs(i(VSC)))+0.004*(v(p)/2-v(mid))*sgn(i(VSC)),0.02),0.98)
BGA ga 0 V=v(da)>v(tri)?1:0
BGB gb 0 V=v(db)>v(tri)?1:0
BGC gc 0 V=v(dc)>v(tri)?1:0
.tran 0.5u 0.002 0 0.2u uic
.option method=gear reltol=2e-3 abstol=1u vntol=10u
.control
set filetype=ascii
run
wrdata probe.out v(da) v(tri) v(ga) i(VSA) v(a) v(pha)
quit
.endc
.end
