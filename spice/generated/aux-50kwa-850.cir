* aux flyback rev C VIN=850 (full bus, E26 rev C, 110 W stage)
VIN vin 0 DC 850
* primary: Lp 345u with switch to ground via sense R; RCD clamp
LP vin sw 345u
BSW sw csn I=v(sw,csn)*(1e-7+v(g)*20)
RCS csn 0 0.31
RCSF csn csnf 200
CCSF csnf 0 1n
DCL sw cl DCLP
CCL cl vin 10n ic=0
RCL cl vin 94k
.model DCLP D(Is=1e-9 N=1.8 Rs=0.1 BV=1200 IBV=1m)
* secondaries (coupled): N24 6/38 -> 8.6u, N15 4/38 -> 3.82u (D4 rev C)
LS24 s24a 0 8.6u
LS15 s15a 0 3.82u
K1 LP LS24 0.998
K2 LP LS15 0.998
K3 LS24 LS15 0.998
* CB-19 regression: rectifiers modeled WITH breakdown at the specified 400 V rating —
* PIV ≈ Vo + VIN·n ≈ 160 V at 860 V bus; a 100 V model here would avalanche visibly.
D24 s24a v24 DSCH
D15 s15a v15 DSCH
.model DSCH D(Is=1e-7 N=1.05 Rs=0.02 BV=400 IBV=1m)
C24 v24 0 220u ic=0
C15 v15 0 220u ic=0
* loads (per-SKU): 24 V hold 1 A stepping to 2.4 A; 15 V 1.2 A
BL24 v24 0 I=max(v(v24),0)/24*(1+1.4*u(time-0.012))
RL15 v15 0 12.5
* control: voltage-mode P on 24 V rail, duty 0.03..0.45, soft-start ramp; 65 kHz sawtooth
BTRI tri 0 V=time*65000-floor(time*65000)
BDUT dut 0 V=min(max(0.35*(24.5-v(v24f)),0.002),min(0.45,time/5m+0.03))
* PWM AND cycle-by-cycle CS clamp (1.0 V / 0.31 R = 3.2 A) AND light-load skip (as NCP1252A):
* the 110 W stage at min duty over-delivers into a 30 kW idle load without cycle skipping
BGT g 0 V=min(max((v(dut)-v(tri))*60+0.5,0),1)*min(max((1.0-v(csnf))*60+0.5,0),1)*min(max((24.9-v(v24f))*20+0.5,0),1)
RF1 v24 v24f 1k
CF1 v24f 0 100n
.tran 0.4u 0.02 0 0.2u uic
.option method=gear reltol=2e-3 abstol=1e-6 itl4=100
.control
set filetype=ascii
run
wrdata aux-50kwa-850.out v(v24) v(v15) i(VIN)
quit
.endc
.end
