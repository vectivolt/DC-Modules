* generated DPT SIC750_10R V=425 I=50.7 Rgon=4.7 Rgoff=2.2 Lloop=1.8e-8
.include ../models/sic-behavioral.lib
VBUS bus 0 DC 425
CDC bus 0 100u ic=425
LLP bus kd 1.8e-8
DFW sw kd JBS1200_40
* no snubber
* no clamp
LLD kd sw 0.000042 ic=0
VSNS sw d1 0
LD d1 d 2n
M1 d g ks SIC750_10R
LKS ks s 1.5n
LSP s 0 2n
VDRV drv ks PWL(0 -4 1e-7 -4 1.05e-7 18 0.0000051103529411764705 18 0.0000051153529411764705 -4 0.0000066103529411764706 -4 0.0000066153529411764705 18 0.0000074103529411764705 18 0.0000074153529411764705 -4)
RGN drv gon 4.7
DGN gon g DIDEAL
DGF g goff DIDEAL
RGF goff drv 2.2
.model DIDEAL D(Is=1e-3 N=0.1)
.tran 0.25n 0.00000801035294117647 uic
.option method=gear reltol=1e-3 abstol=1u vntol=1m
.control
set filetype=ascii
run
wrdata dpt-pfc750-i51.out v(d,ks) v(g,ks) i(VSNS) v(sw)
quit
.endc
.end
