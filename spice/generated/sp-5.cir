* parallel closure with 5 V mismatch
CA a 0 0.0015 ic=402.5
CB b 0 0.0015 ic=397.5
* relay closes at t=1ms: contact R ramps 1meg -> 2 mOhm over 100 us (arc/bounce abstracted)
BREL a c I=v(a,c)/(0.002+1e6*(1-min(max((time-1m)/100u,0),1)))
LW c b 50n
RW c2 b 1u
.tran 1u 6m uic
.option method=gear reltol=1e-3
.control
set filetype=ascii
run
wrdata sp-5.out v(a,b) i(LW)
quit
.endc
.end
